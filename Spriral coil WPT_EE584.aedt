# Ansys Electronics Desktop project, version 2023.2
materials:
  vacuum: permittivity=1
  copper: permeability=0.999991 conductivity=58000000

design Maxwell3DDesign1 (Maxwell 3D, Magnetostatic, model units mm)
variables:
  distt = 20mm
  i = 1A
geometry:
  Tx [copper] = user_primitive(Examples/RectangularSpiral.py, Xpos=0mm, Ypos=0mm, Dist=6mm, Turns=10, Width=3mm, Thickness=3mil)
  vaccumbox [vacuum] = box(corner=(-500mm, -500mm, -500mm), size=(1000mm, 1000mm, 1000mm))
  Box1 = box(corner=(0mm, -61.5mm, 0mm), size=(1mm, 1mm, 2mm))
  Box2 = box(corner=(0mm, -1.5mm, 0.0381mm), size=(-1mm, 1mm, 2mm))
  Box3 = box(corner=(0mm, -61.5mm, 2mm), size=(1mm, -600mm, -0.4mm))
  Box4 = box(corner=(-1mm, -1.5mm, 2.0381mm), size=(0.75mm, -700mm, -0.2381mm))
  Tx.unite(Box4, Box3, Box2, Box1)
  Box5 = box(corner=(-500mm, -500mm, 500mm), size=(1000mm, -700mm, -1000mm))
  Tx.subtract(Box5)
  Rx [copper] = user_primitive(Examples/RectangularSpiral.py, Xpos=0mm, Ypos=0mm, Dist=6mm, Turns=10, Width=3mm, Thickness=3mil)
  Box9 = box(corner=(-1mm, -1.5mm, 2.0381mm), size=(0.75mm, -700mm, -0.2381mm))
  Box8 = box(corner=(0mm, -61.5mm, 2mm), size=(1mm, -600mm, -0.4mm))
  Box7 = box(corner=(0mm, -1.5mm, 0.0381mm), size=(-1mm, 1mm, 2mm))
  Box6 = box(corner=(0mm, -61.5mm, 0mm), size=(1mm, 1mm, 2mm))
  Rx.unite(Box9, Box8, Box7, Box6)
  Box10 = box(corner=(-500mm, -500mm, 500mm), size=(1000mm, -700mm, -1000mm))
  Rx.subtract(Box10)
  Rx.move(0mm, 0mm, distt)
  Region [vacuum] = region(percentage_offset=0 on all sides)
  Rectangle1 [copper, non-model] = rectangle(corner=(-50mm, 50mm, 10mm), x_size=100mm, y_size=-100mm)
boundaries and excitations:
  Tx_in: Current Faces=Tx.face(at (0.5, -500, 1.8)) Current=i IsSolid=true Point_out_of_terminal=false
  Tx_out: Current Faces=Tx.face(at (-0.625, -500, 1.91905)) Current=i IsSolid=true Point_out_of_terminal=true
  Rx_in: Current Faces=Rx.face(at (0.5, -500, 21.8)) Current=i IsSolid=true Point_out_of_terminal=false
  Rx_out: Current Faces=Rx.face(at (-0.625, -500, 21.9191)) Current=i IsSolid=true Point_out_of_terminal=true
parameters:
  Matrix1: Matrix Rx_in, Tx_in: NumberOfTurns=1
mesh:
  BoxMesh: LengthBased RefineInside Objects=vaccumbox MaxLength=200mm
  CoilMesh: LengthBased Objects=[Tx, Rx] MaxLength=100mm
  initial mesh: GlobalCurvilinear{Apply}
setups:
  Setup1: Magnetostatic MaximumPasses=10 MinimumPasses=5 MinimumConvergedPasses=1 PercentRefinement=30 PercentError=10 RelativeResidual=1e-06 NonLinearResidual=0.001
optimetrics:
  ParametricSetup1: Parametric Sim._Setups=[Setup1]
    sweep distt: LIN 10mm 20mm 5mm
    calculate Matrix1.CplCoef(Tx_in,Rx_in) on Setup1 : LastAdaptive
field plots:
  Mag_B1: B over a plane on Setup1 : LastAdaptive
reports:
  L Table 1: Matrix1.L(Rx_in,Rx_in) vs distt on Setup1 : LastAdaptive
